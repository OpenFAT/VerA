// Self-timed sequencer — behavioural golden model, ports 1:1 with netlist/async_ctrl.
// go rises -> xbar_rst high for t_rst -> settle for t_settle -> adc_go high;
// latch_out and done follow adc_done. go low returns every phase output low.
//
// Continuous form (OpenVAF subset: no @(cross), no transition(), no absdelay): tanh
// thresholds at VDD/2, one internal RC node per delay chain whose 50% crossing lands at
// the chain delay, Thevenin outputs (rout). Not modelled: the few-hundred-ps inverter
// buffer delays (go -> xbar_rst, adc_done -> done), edge rates, supply current.
`include "disciplines.vams"
`include "constants.vams"

module async_ctrl(go, adc_done, xbar_rst, adc_go, latch_out, done, vdd, vss);
    inout go, adc_done, xbar_rst, adc_go, latch_out, done, vdd, vss;
    electrical go, adc_done, xbar_rst, adc_go, latch_out, done, vdd, vss;
    electrical r, s;                                   // reset / settle chain states

    parameter real t_rst = 21.5e-9 from (0:inf);       // reset pulse width (s)
    parameter real t_settle = 48e-9 from (0:inf);      // settle phase (s)
    parameter real rout = 1e3 from (0:inf);            // output resistance (ohm)

    real vdd_, g, rd, sd, a, rf;

    analog function real hi;                           // 0/1 logic level of v
        input v, vdd_;
        real v, vdd_;
        hi = 0.5 * (1.0 + tanh((v - vdd_ / 2) / 0.02));
    endfunction

    analog begin
        vdd_ = V(vdd, vss);
        rf = 1e3;
        g = hi(V(go, vss), vdd_);
        rd = hi(V(r, vss), vdd_);
        sd = hi(V(s, vss), vdd_);
        a = hi(V(adc_done, vss), vdd_);
        // chain states: RC with 50% crossing at the chain delay after its input switches
        I(r, vss) <+ (V(r, vss) - g * vdd_) / rf;
        I(r, vss) <+ t_rst / (rf * ln(2.0)) * ddt(V(r, vss));
        I(s, vss) <+ (V(s, vss) - rd * vdd_) / rf;
        I(s, vss) <+ t_settle / (rf * ln(2.0)) * ddt(V(s, vss));
        I(xbar_rst, vss) <+ (V(xbar_rst, vss) - g * (1.0 - rd) * vdd_) / rout;
        I(adc_go, vss) <+ (V(adc_go, vss) - sd * vdd_) / rout;
        I(latch_out, vss) <+ (V(latch_out, vss) - a * vdd_) / rout;
        I(done, vss) <+ (V(done, vss) - a * vdd_) / rout;
    end
endmodule
