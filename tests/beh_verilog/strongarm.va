// StrongARM comparator — behavioural golden model, ports 1:1 with netlist/strongarm.
// clk high: vinp > vinn + voff -> outp LOW / outn HIGH, else the reverse.
// clk low: both outputs precharged to vdd.
//
// Continuous form (OpenVAF subset: no @(cross), no transition()): tanh switching on clk
// and on the input difference, an internal RC per output for the clk->decision delay
// (~td), and a Thevenin output (rout) into the testbench load.
// Not a latch: while clk is high the outputs follow the input sign instead of holding
// the value sampled at the edge — equivalent for static inputs across a decision.
`include "disciplines.vams"
`include "constants.vams"

module strongarm(vinp, vinn, outp, outn, clk, vdd, vss);
    inout vinp, vinn, outp, outn, clk, vdd, vss;
    electrical vinp, vinn, outp, outn, clk, vdd, vss;
    electrical fp, fn;                              // delayed internal decisions

    parameter real voff = 0.0 from [-0.1:0.1];      // input-referred offset (V)
    parameter real vres = 100e-6 from (0:inf);      // decision resolution (V)
    parameter real td = 0.5e-9 from (0:inf);        // clk -> decision (s)
    parameter real rout = 1e3 from (0:inf);         // output resistance (ohm)

    real on, d, rf, cf;

    analog begin
        on = 0.5 * (1.0 + tanh((V(clk, vss) - V(vdd, vss) / 2) / 0.02));
        d = tanh((V(vinp, vinn) - voff) / vres);    // +1: vinp wins
        rf = 1e3;
        cf = td / (rf * ln(2.0));                   // 50% crossing at td
        I(fp, vss) <+ (V(fp, vss) - (1.0 - on * (1.0 + d) / 2) * V(vdd, vss)) / rf;
        I(fp, vss) <+ cf * ddt(V(fp, vss));
        I(fn, vss) <+ (V(fn, vss) - (1.0 - on * (1.0 - d) / 2) * V(vdd, vss)) / rf;
        I(fn, vss) <+ cf * ddt(V(fn, vss));
        I(outp, vss) <+ (V(outp, vss) - V(fp, vss)) / rout;
        I(outn, vss) <+ (V(outn, vss) - V(fn, vss)) / rout;
    end
endmodule
