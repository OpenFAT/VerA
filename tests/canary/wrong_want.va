// CANARY: the want is wrong (the branch potential is 1.25 V, not 1.5 V). The
// harness must FAIL it on its `ok=0`; see EXPECT.tsv.
//! lrm 5.6.3
//! bias V(p) = 1.5, V(n) = 0.25
`include "check.vh"
module canary_wrong_want(p, n);
  inout p, n; electrical p, n;
  analog begin
    `CHECKX("branch potential, with a wrong want", V(p, n), 1.5);
    I(p, n) <+ V(p, n) / 1k;
  end
endmodule
