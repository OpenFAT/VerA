// CANARY: the named neighbour is itself a refusal, so it is no legal variant.
//! lrm 5.10.3.3
//! reject-only E0517
//! neighbour reject_wrong_code.va
`include "disciplines.vams"
module canary_neighbour_negative(p);
  inout p; electrical p;
  integer k;
  analog begin
    @(timer(1n, 2n, -1p)) k = k + 1;
    I(p) <+ 0.0;
  end
endmodule
