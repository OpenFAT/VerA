// CANARY: one check, but `//! checks 2`. A missing observation must FAIL.
//! lrm 5.6.3
//! bias V(p) = 1.5, V(n) = 0.25
//! checks 2
`include "check.vh"
module canary_checks_off_by_one(p, n);
  inout p, n; electrical p, n;
  analog begin
    `CHECKX("branch potential", V(p, n), 1.25);
    I(p, n) <+ V(p, n) / 1k;
  end
endmodule
