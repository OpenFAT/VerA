// CANARY: marked `//! xfail` but correct, so it passes: an XPASS, which the
// harness must FAIL so a marker cannot outlive its limitation.
//! lrm 5.6.3
//! bias V(p) = 1.5, V(n) = 0.25
//! xfail canary: this fixture passes
`include "check.vh"
module canary_xpass(p, n);
  inout p, n; electrical p, n;
  analog begin
    `CHECKX("branch potential", V(p, n), 1.25);
    I(p, n) <+ V(p, n) / 1k;
  end
endmodule
