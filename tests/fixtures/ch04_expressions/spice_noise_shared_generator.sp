* LRM 4.6.4.6: "Perfectly correlated noise is generated by using the output
* of one noise function for more than one noise source." The model puts one
* white_noise n (1e-18 A^2/Hz) on two branches, 2*n on out-0 and -3*n on
* x-0, and a host must add the two contributions as phasors of ONE source.
*
* Conductances at out: the model's g1 = 1 mS to 0, R1 = 1k to in (a short
* in the small-signal problem), g3 = 1 mS to x; at x: g2 = 2 mS to 0 and
* g3. Y = [[3m, -1m], [-1m, 3m]], det = 8e-6, so the transfer impedances to
* out are Z_oo = 3e-3/8e-6 = 375 and Z_ox = 1e-3/8e-6 = 125 ohm, real (no
* charge). One generator, so
*     H = 2*375 + (-3)*125 = 375 ohm, onoise = 375 * sqrt(1e-18) = 3.75e-7
* V/sqrt(Hz) at every frequency. Two independent sources would give
* sqrt(750^2 + 375^2) * 1e-9 = 8.385e-7; one source with the sign dropped,
* (750 + 375) * 1e-9 = 1.125e-6.
*
* The sweep is oct 1 from 1k to 4k: 1k, 2k, 4k (the next, 8k, is past
* 4k*(1 + 2e-3)).
*
* R1 is noisy=0: a SPICE resistor carries 4kT/R by default, and this deck
* isolates the model's one generator, whose two contributions are the claim.
* Expected results: spice_noise_shared_generator.expected.json
.hdl "spice_noise_shared_pair.va"
V1 in 0 DC 0 AC 1
R1 in out 1k noisy=0
Np out x 0 spice_noise_shared_pair
.noise v(out) V1 oct 1 1k 4k
.end
