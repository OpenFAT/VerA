// §4.6.4.4 noise_table_log — the clause's own worked example, and the export
// that keeps it distinguishable from §4.6.4.3's.
//
//     V(out) <+ noise_table_log('{1,1, 1e6,1e-6});
//
// "The noise_table_log() function produces a straight line on a log-log plot
// from just two points", whereas the same two points read by noise_table() give
// "a series of curves between the interpolating points" (Figure 4-14). The two
// functions therefore differ ONLY in interpolation — same argument, same
// clamping outside the range, same generator — which is why they export one
// `table` kind and the difference lives in the table's own interpolation mode.
//
// A dc point has no frequency (§4.6.2), so nothing the model can read here
// tells the two apart; what a fixture can assert is that a generator was
// declared on this branch at all, and the rest is graded by the interpolation
// tests in tools/contract.zig, which compute the clause's `pow(10, log(p1) +
// …)` independently of the evaluator.
//
// Two generators on one branch, which is also §4.6.4's own shape ("multiple
// noise contributions to a single branch are combined"): a white one and a
// tabulated one, so the `table` row cannot be the only row and a lowering that
// overwrote one kind with the other would be caught. Both are voltages in
// series with the branch (§4.6.4.1, a potential contribution), so both sit
// row == col on its current unknown `flow(out,gnd_ref)`, whose `U` tag is
// that name with its punctuation Z-escaped.
//
//! lrm 4.6.4.4
//! lrm 4.6.2
//! noise thermal(flowZ28outZ2cgnd_refZ29,flowZ28outZ2cgnd_refZ29)#0
//! noise table(flowZ28outZ2cgnd_refZ29,flowZ28outZ2cgnd_refZ29)#1
//! analysis dc
//! bias V(out) = 0.0
//! bias V(gnd_ref) = 0.0
`include "check.vh"
module ch04_noise_table_log_topology(out, gnd_ref);
    inout out, gnd_ref;
    electrical out, gnd_ref;

    analog begin
        V(out, gnd_ref) <+ white_noise(1e-18, "white")
            + noise_table_log('{1.0, 1.0, 1e6, 1e-6}, "log-table");
        `CHECKX("noise_table_log is inactive outside a small-signal analysis",
            noise_table_log('{1.0, 1.0, 1e6, 1e-6}), 0.0);
        `CHECKX("and so is the branch it is the whole content of", V(out, gnd_ref), 0.0);
    end
endmodule
