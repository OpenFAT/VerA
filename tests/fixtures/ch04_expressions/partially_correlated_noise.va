// §4.6.4.6 Example 2 — "Partially correlated noise is generated by combining
// the output of shared and unshared noise functions." This is the clause's own
// printed module, three `white_noise` calls into three variables:
//
//     n1  = white_noise(1-corr);
//     n2  = white_noise(1-corr);
//     n12 = white_noise(corr);
//     V(a,b) <+ Kv*(n1 + n12);
//     I(b,c) <+ Ki*(n2 + n12);
//
// What the export must say, and the `//! noise` lines assert row by row: each
// CALL is one generator ("each noise function generates noise which is
// uncorrelated with the noise generated by other functions"), so `n1` and `n2`
// carry DISTINCT source ids even though their power expressions are textually
// identical — while `n12`, one call used on both branches, carries the SAME id
// on both rows. Four rows, three sources: #0/#2 unshared, #1 shared, which is
// exactly the partial correlation the clause describes and the only encoding
// of it a host can act on. The two rows of the potential contribution are
// voltages in series with branch (a,b) (§4.6.4.1): row == col on its current
// unknown `flow(a,b)`, whose `U` tag Z-escapes the punctuation; the flow
// contribution's rows are currents between b and c.
//
// The dc values are §4.6's "when not active, the small-signal source functions
// return zero (0)": every combination is exactly 0.0 here, so the potential
// branch retains 0 V and the flow branch 0 A whatever `corr` is.
//
//! lrm 4.6.4.6
//! lrm 4.6.4.6:1000
//! noise thermal(flowZ28aZ2cbZ29,flowZ28aZ2cbZ29)#0
//! noise thermal(flowZ28aZ2cbZ29,flowZ28aZ2cbZ29)#1
//! noise thermal(b,c)#2
//! noise thermal(b,c)#1
//! analysis dc
//! bias V(a) = 0.0
//! bias V(c) = 0.0
`include "check.vh"
module ch04_partially_correlated_noise(a, b, c);
    inout a, b, c;
    electrical a, b, c;
    parameter real corr = 0.5 from [0:1];
    parameter real Kv = 2.0;
    parameter real Ki = 3.0;
    real n1, n2, n12;

    analog begin
        n1  = white_noise(1 - corr, "unshared1");
        n2  = white_noise(1 - corr, "unshared2");
        n12 = white_noise(corr, "shared");
        `CHECKX("an unshared source is inactive in a dc analysis", n1, 0.0);
        `CHECKX("and so is the shared one", n12, 0.0);
        `CHECKX("and so is the scaled combination", Ki * (n2 + n12), 0.0);
        V(a, b) <+ Kv * (n1 + n12);
        I(b, c) <+ Ki * (n2 + n12);
    end
endmodule
