// §6.3.6 $mfactor automatic scaling, the fourth rule: "Contributions to a
// branch potential quantity using the noise functions shall have the noise
// power divided by $mfactor." m identical series noise voltages placed in
// parallel average out: the open-circuit noise power of the bank is 1/m of one.
//
// The child contributes `white_noise(1.0, "w")` to a potential, 1 V^2/Hz for
// one copy (§4.6.4.1), and is placed with `.$mfactor(4.0)` directly across the
// parent's ports p and n. As in the flow case, a noise source has no value
// outside a small-signal noise analysis (§4.6.4), so the assertion is the
// published density the `//! noise` line reads from `noisePsd`.
//
// BY HAND: 1.0 / 4 = 0.25 V^2/Hz on the branch (p,n). Unscaled it reads 1.0;
// multiplied (the flow rule applied to a potential) it reads 4.0. A series
// voltage sits row == col on the branch current `flow(p,n)` (§4.6.4.1),
// whose `U` tag is that name with its punctuation Z-escaped.
//
// THE COUNT, from tb/runner.zig: one CHECKX, then the runner's noise lines
// for one `//! noise` entry: the table count, the row's topology, its name
// and its white density. 1 + 4 = 5.
//
// mfactor_potential_noise.va pins the top-level case, where $mfactor is 1.0.
//
//! lrm 6.3.6
//! lrm 6.3.6:6
//! noise thermal(flowZ28pZ2cnZ29,flowZ28pZ2cnZ29)#0 name=w white=0.25
//! analysis noise
//! bias V(p) = 0.0, V(n) = 0.0
//! checks 5
`include "check.vh"
module b4_mvn_top(p, n);
  inout p, n; electrical p, n;
  b4_mvn_src #(.$mfactor(4.0)) u(p, n);
endmodule

module b4_mvn_src(a, b);
  inout a, b; electrical a, b;
  analog begin
    `CHECKX("Table 9-29: the instance's $mfactor is 1.0 * 4.0", $mfactor, 4.0);
    V(a, b) <+ white_noise(1.0, "w");
  end
endmodule
