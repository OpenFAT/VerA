// An implicit contribution (LRM 5.6.6): I(b) appears on both sides, and the
// solver finds the value that satisfies the equation. After the conformance
// suite's verilog-a/ch05_analog_behavior/implicit_flow_equation_is_solved:
//   s --[ b: I = gm*(V(b) - rs*I) ]-- m --[ rl ]-- ground
//   I = gm*(1 - V(m) - rs*I) with gm*rs = 0.5*2 = 1:  2*I = 0.5*(1 - V(m))
//   I = V(m)/rl = V(m)/4                          :  V(m) = 4*I
//   so 2*I = 0.5 - 2*I, I = 0.125 A, V(m) = 0.5 V.
//! bias V(s) = 1
//! solve
//! print none
`include "disciplines.vams"

module implicit(s);
  inout s;
  electrical s, m;
  parameter real gm = 0.5 from (0:inf);
  parameter real rs = 2 from [0:inf);
  parameter real rl = 4 from (0:inf);
  branch (s, m) b;
  analog begin
    I(b) <+ gm * (V(b) - rs * I(b));
    I(m) <+ V(m) / rl;
    $strobe("I(b) = %g A, V(m) = %g V", I(b), V(m));
  end
endmodule
